// GATOR_TESTS/ota7_m5_v2/schematic
subckt ota7_m5_v2 VBIAS VDD VINN VINP VOUT VSS
    M7 (VOUT VBIAS VSS VSS) g45n1svt w=(2u) l=1u nf=1 m=(1)
    M5 (NTAIL VBIAS VSS VSS) g45n1svt w=(4u) l=1u nf=1 m=(1)
    M2 (NSTAGE VINP NTAIL VSS) g45n1svt w=(4u) l=500n nf=1 m=(1)
    M1 (NLOAD VINN NTAIL VSS) g45n1svt w=(4u) l=500n nf=1 m=(1)
    M6 (VOUT NSTAGE VDD VDD) g45p1svt w=(8u) l=500n nf=1 m=(1)
    M4 (NSTAGE NLOAD VDD VDD) g45p1svt w=(8u) l=500n nf=1 m=(1)
    M3 (NLOAD NLOAD VDD VDD) g45p1svt w=(8u) l=500n nf=1 m=(1)
    CC (NSTAGE VOUT) capacitor c=1p
ends ota7_m5_v2

// GATOR_TESTS/tb_ota7_m5_ac_v2/schematic
XU1 (VBIAS VDD VINN VINP VOUT 0) ota7_m5_v2
VN (VINN 0) vsource dc=600.0m mag=500.0m phase=180 type=dc
VP (VINP 0) vsource dc=600.0m mag=500.0m phase=0 type=dc
VB (VBIAS 0) vsource dc=400.0m mag=0 phase=0 type=dc
VDD (VDD 0) vsource dc=1.0 mag=0 phase=0 type=dc
CL (VOUT 0) capacitor c=1p
