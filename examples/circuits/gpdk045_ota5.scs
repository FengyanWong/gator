// GATOR_TESTS/ota5_v1/schematic
subckt ota5_v1 VBIAS VDD VINN VINP VOUT VSS
    M5 (NTAIL VBIAS VSS VSS) g45n1svt w=(4u) l=1u nf=1 m=(1)
    M2 (VOUT VINN NTAIL VSS) g45n1svt w=(4u) l=500n nf=1 m=(1)
    M1 (NLOAD VINP NTAIL VSS) g45n1svt w=(4u) l=500n nf=1 m=(1)
    M4 (VOUT NLOAD VDD VDD) g45p1svt w=(8u) l=500n nf=1 m=(1)
    M3 (NLOAD NLOAD VDD VDD) g45p1svt w=(8u) l=500n nf=1 m=(1)
ends ota5_v1

// GATOR_TESTS/tb_ota5_ac_v1/schematic
XU1 (VBIAS VDD VINN VINP VOUT 0) ota5_v1
VN (VINN 0) vsource dc=600.0m mag=500.0m phase=180 type=dc
VP (VINP 0) vsource dc=600.0m mag=500.0m phase=0 type=dc
VB (VBIAS 0) vsource dc=400.0m mag=0 phase=0 type=dc
VDD (VDD 0) vsource dc=1.0 mag=0 phase=0 type=dc
CL (VOUT 0) capacitor c=1p
