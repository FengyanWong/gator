// GATOR_TESTS/ldo_m6_v1/schematic
subckt ldo_m6_v1 VBIAS VDD VOUT VREF VSS
    M5 (NTAIL VBIAS VSS VSS) g45n1svt w=(4u) l=1u nf=1 m=(1)
    M2 (VGATE VREF NTAIL VSS) g45n1svt w=(4u) l=500n nf=1 m=(1)
    M1 (NLOAD VFB NTAIL VSS) g45n1svt w=(4u) l=500n nf=1 m=(1)
    MP (VOUT VGATE VDD VDD) g45p1svt w=(8u) l=500n nf=1 m=(1)
    M4 (VGATE NLOAD VDD VDD) g45p1svt w=(8u) l=500n nf=1 m=(1)
    M3 (NLOAD NLOAD VDD VDD) g45p1svt w=(8u) l=500n nf=1 m=(1)
    RDN (VFB VSS) resistor r=600K
    RUP (VOUT VFB) resistor r=200K
ends ldo_m6_v1

// GATOR_TESTS/tb_ldo_m6_v1/schematic
XU1 (VBIAS VDD VOUT VREF 0) ldo_m6_v1
VB (VBIAS 0) vsource dc=400.0m mag=0 phase=0 type=dc
VREF (VREF 0) vsource dc=600.0m mag=0 phase=0 type=dc
VDD (VDD 0) vsource dc=1.0 mag=1 phase=0 type=dc
COUT (VOUT 0) capacitor c=10n
ILOAD (VOUT 0) isource dc=10u mag=0 type=pulse val0=10u val1=20u period=200u delay=10u rise=100n fall=100n width=100u
