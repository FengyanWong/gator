// GPDK045_RINGOSC/ring_osc_3stage/schematic
subckt ring_osc_3stage OUT VDD VSS
    MP3 (OUT N2 VDD VDD) g45p1svt w=(2u) l=45n nf=1 m=(1)
    MP2 (N2 N1 VDD VDD) g45p1svt w=(2u) l=45n nf=1 m=(1)
    MP1 (N1 OUT VDD VDD) g45p1svt w=(2u) l=45n nf=1 m=(1)
    MN3 (OUT N2 VSS VSS) g45n1svt w=(1u) l=45n nf=1 m=(1)
    MN2 (N2 N1 VSS VSS) g45n1svt w=(1u) l=45n nf=1 m=(1)
    MN1 (N1 OUT VSS VSS) g45n1svt w=(1u) l=45n nf=1 m=(1)
    C3 (OUT VSS VSS) g45cmim w=4.49u l=4.49u m=2
    C2 (N2 VSS VSS) g45cmim w=4.49u l=4.49u m=2
    C1 (N1 VSS VSS) g45cmim w=4.49u l=4.49u m=2
ends ring_osc_3stage

// GPDK045_RINGOSC/tb_ring_osc_3stage/schematic
XU1 (OUT VDD 0) ring_osc_3stage
V0 (VDD 0) vsource dc=1.0 type=dc
